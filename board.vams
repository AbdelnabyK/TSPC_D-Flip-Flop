// This module is a kind of test board fot the device under test (DUT)
// This module is written in "Verilog-AMS" language
//
// it's function is :
// - to generate electrical signals for the DUT
// - to extract measurements
// - to send measurements to the digital testbench
//
// 1/ The device under test is an INVERTOR
//
// 2/ The expected measurement is the "propagation time, for a falling output"

`timescale 1ns/100fs
`default_nettype none

// Mandatory for  AMS
//`include "constants.vams"
`include "disciplines.vams"

// The board
module board(
                        // From the testbench
			clk_logic,
                        din_logic          ,
                        load_capacitor_val , // The expected value of a load capacitor loading the output of the invertor
                        din_tt_val             , // The expected value of the transition time of the input
                        clk_tt_val             ,
			din_delay_val          , // An arbitrary incremental delay added to the input transition
                        clk_delay_val          ,
			// To the testbench
                        propagation_time,     // The measured output transition time for a falling output
                        dout_electrical     // The output of the  dut

			) ;

// IO defs
input   clk_logic          ;
input   din_logic          ;
input   load_capacitor_val ;
input   din_tt_val             ;
input   din_delay_val          ;
input   clk_tt_val             ;
input   clk_delay_val          ;
output  propagation_time    ;
output  dout_electrical    ;

// Nature of the signal
wire  clk_logic          ;
wire  din_logic          ;
wreal load_capacitor_val ;
wreal din_tt_val             ;
wreal din_delay_val          ;
wreal clk_tt_val             ;
wreal clk_delay_val          ;
wreal propagation_time    ;
electrical dout_electrical    ;

// Static parameters for the characterization
parameter real  power_voltage = 1.1 ; // volts
parameter real  slew_lower_threshold_pct 	= 0.3 ; // Fraction of the full swing
parameter real  slew_upper_threshold_pct 	= 0.7 ; // Fraction of the full swing
localparam real  input_threshold_pct      	= 0.5 ; // Fraction of the full swing
localparam real  output_threshold_pct      	= 0.5 ; // Fraction of the full swing

///////////////////////////////////////////////////////////////
// The analog world...
///////////////////////////////////////////////////////////////

// Internal Signals
electrical din_electrical     ;
electrical clk_electrical     ;

// nodes for power supplies
electrical vss          ;
ground vss              ;
electrical vdd          ;
electrical tmp ;

// Branches for power supplies, passive dipoles...
branch (vdd,vss) power_dut                ;
branch (dout_electrical,vss) load_capacitor   ;
branch (tmp,vss) tmp_val;

// Equations for the branches
analog
begin
 // The power_dut branch is an ideal voltage source
 V(power_dut) <+ power_voltage ;
 // The load_capacitor branch is an ideal capacitor
 // Smooth the capacitor update in order to limit simulator convergence problems
 I(load_capacitor) <+ ddt(V(load_capacitor))*transition(load_capacitor_val,0,1p,1p);

 //I(load_capacitor) <+ ddt(V(load_capacitor))*load_capacitor_val ;
end

// Here we generate the input transition using the variables transmitted by the testbench
cmos_transition cmos_tr_din(.din(din_logic),.dout(din_electrical),.tt_val(din_tt_val),.delay_val(din_delay_val)) ;

cmos_transition cmos_tr_clk(.din(clk_logic),.dout(clk_electrical),.tt_val(clk_tt_val),.delay_val(clk_delay_val)) ;
// The device under test is simply connected to the signals.
// All gates from the gsclib045 may be used in this netlist.
//INV dut (.VDD(vdd),.VSS(vss),.A(din_electrical),.Y(dout_electrical)) ;

///////////////////////////////////////////////////////////////
// The measurements
///////////////////////////////////////////////////////////////

TSPCFFF dut (.VDD(vdd), .VSS(vss), .CK(clk_electrical), .D(din_electrical), .QQ(dout_electrical));

///////////////////////////////////////////////////////////////

// Transition time for a falling output
///////////////////////////////////////////////////////////////
real start_setup_transition ;
real stop_setup_transition  ;

// We detect the start of a falling transition using slew_upper_threshold_pct.
always @(cross(V(clk_electrical)-power_voltage*input_threshold_pct , 1,1e-15,1e-4 ))
   start_setup_transition = $abstime ;

// We detect the end of a falling transition using slew_lower_threshold_pct
always @(cross(V(dout_electrical)-power_voltage*input_threshold_pct, 1,1e-15,1e-4 ))
  stop_setup_transition = $abstime   ;
// We compute and transmit the measured propagation time to the testbench
// transmission des valeurs calculees vers le monde numerique

assign propagation_time =  (stop_setup_transition - start_setup_transition) ;

// setup time :

// hold time :

endmodule
